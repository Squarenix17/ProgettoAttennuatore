# Ansys Electronics Desktop project, version 2022.1
project variables:
  $elevation = 3um
  $res_width = 117um  # optimise 50um..125um; tune 0.01mm..0.1mm
  $res_length = 91um  # optimise 50um..150um; tune 50um..150um
  $sheet_res = 90
materials:
  vacuum: permittivity=1
  air: permittivity=1.0006 permeability=1.0000004
  FBK_TIN: conductivity=24300000
  FBK_BRIDGE: conductivity=227273000
  FBK_CPW: conductivity=60606000
  epoxy_Kevlar_xy: permittivity=3.6
  FBK_FLOMET: conductivity=52910000
  FBK_POLY: conductivity=1/(($sheet_res)*(630*(10^(-9))))
  FBK_SI_SUB: permittivity=11.9
  FBK_SI_OX: permittivity=3.94

design HFSSDesign1 (HFSS, DrivenModal, model units mm)
variables:
  g = 0.05mm
geometry:
  Si_sub_1 [FBK_SI_SUB] = imported_body(C:/Users/gabri/AppData/Local/Temp/35631622416575701925..sm3)
  Field_ox_1 [FBK_SI_OX] = imported_body(C:/Users/gabri/AppData/Local/Temp/363A1622416575702589..sm3)
  Fbk_oxide_1 [FBK_SI_OX] = imported_body(C:/Users/gabri/AppData/Local/Temp/369616224165757028612..sm3)
  Air_1 [air] = imported_body(C:/Users/gabri/AppData/Local/Temp/36D716224165757030615..sm3)
  Poly_5..Poly_9 [FBK_POLY] = imported_body(C:/Users/gabri/AppData/Local/Temp/372916224165757033119..sm3)
  Via_1..Via_22 [FBK_FLOMET] = imported_body(C:/Users/gabri/AppData/Local/Temp/37E916224165757039028..sm3)
  Flomet_1..Flomet_5 [FBK_FLOMET] = imported_body(C:/Users/gabri/AppData/Local/Temp/382B16224165757041031..sm3)
  Flomet_6, Flomet_7 = imported_body(C:/Users/gabri/AppData/Local/Temp/382B16224165757041031..sm3)
  Flomet_8 [FBK_FLOMET] = imported_body(C:/Users/gabri/AppData/Local/Temp/382B16224165757041031..sm3)
  Flomet_9, Flomet_10 = imported_body(C:/Users/gabri/AppData/Local/Temp/382B16224165757041031..sm3)
  Flomet_11..Flomet_14 [FBK_FLOMET] = imported_body(C:/Users/gabri/AppData/Local/Temp/382B16224165757041031..sm3)
  Bridge_23 [FBK_BRIDGE] = imported_body(C:/Users/gabri/AppData/Local/Temp/392316224165757048640..sm3)
  Bridge_32, Bridge_33 = imported_body(C:/Users/gabri/AppData/Local/Temp/392316224165757048640..sm3)
  Bridge_34 [FBK_BRIDGE] = imported_body(C:/Users/gabri/AppData/Local/Temp/392316224165757048640..sm3)
  Bridge_35 = imported_body(C:/Users/gabri/AppData/Local/Temp/392316224165757048640..sm3)
  Bridge_36 [FBK_BRIDGE] = imported_body(C:/Users/gabri/AppData/Local/Temp/392316224165757048640..sm3)
  Bridge_37 = imported_body(C:/Users/gabri/AppData/Local/Temp/392316224165757048640..sm3)
  Bridge_38, Bridge_39, Bridge_40 [FBK_BRIDGE] = imported_body(C:/Users/gabri/AppData/Local/Temp/392316224165757048640..sm3)
  CPW_1, CPW_mem [FBK_CPW] = imported_body(C:/Users/gabri/AppData/Local/Temp/396116224165757050543..sm3)
  CPW_3..CPW_15 = imported_body(C:/Users/gabri/AppData/Local/Temp/396116224165757050543..sm3)
  CPW_16 [FBK_CPW] = imported_body(C:/Users/gabri/AppData/Local/Temp/396116224165757050543..sm3)
  CPW_17 = imported_body(C:/Users/gabri/AppData/Local/Temp/396116224165757050543..sm3)
  CPW_18 [FBK_CPW] = imported_body(C:/Users/gabri/AppData/Local/Temp/396116224165757050543..sm3)
  CPW_19 = imported_body(C:/Users/gabri/AppData/Local/Temp/396116224165757050543..sm3)
  CPW_20 [FBK_CPW] = imported_body(C:/Users/gabri/AppData/Local/Temp/396116224165757050543..sm3)
  CPW_21, CPW_22 = imported_body(C:/Users/gabri/AppData/Local/Temp/396116224165757050543..sm3)
  CPW_23, CPW_24 [FBK_CPW] = imported_body(C:/Users/gabri/AppData/Local/Temp/396116224165757050543..sm3)
  CPW_25, CPW_26 = imported_body(C:/Users/gabri/AppData/Local/Temp/396116224165757050543..sm3)
  WavePort1 = rectangle(corner=(0.345mm, -0.2625mm, 0.42031mm), y_size=0.525mm, z_size=0.225mm)
  WavePort2 = WavePort1.duplicate_around_axis(axis=Z, angle=180deg, total=2)
  Region [vacuum] = region(percentage_offset=0 on all sides)
  Bridge_mem [FBK_BRIDGE] = imported_body()
  Bridge_38.unite(Bridge_37, Bridge_32)
  Bridge_36.unite(Bridge_35, Bridge_33)
  CPW_mem.unite(CPW_3..CPW_15, CPW_26, CPW_25)
  CPW_16.unite(CPW_17, CPW_22)
  CPW_18.unite(CPW_19, CPW_21)
  Flomet_8.unite(Flomet_9, Flomet_10)
  Flomet_5.unite(Flomet_6, Flomet_7)
  [CPW_mem, Bridge_mem].move(0mm, 0mm, $elevation)
  Box1 [FBK_POLY] = box(corner=(-($res_length/2), -$res_width/2, 0.52663mm), size=($res_length, $res_width, -0.00063mm))
  Box2 [FBK_TIN] = box(corner=(($res_length/2)-5um, ($res_width/2)-5um, 0.52693mm), size=(-0.015mm, -$res_width+10um, -0.0003mm))
  Box4 [FBK_TIN] = box(corner=(0.17mm, ($res_width/2), 0.52756mm), size=(-0.17mm+($res_length/2)-25um, -$res_width, -0.00063mm))
  Box5 [FBK_TIN] = box(corner=(-0.17mm, -($res_width/2), 0.52756mm), size=(0.17mm-($res_length/2)+25um, $res_width, -0.00063mm))
  Box2_1 [FBK_TIN] = Box2.duplicate_around_axis(axis=Z, angle=180deg, total=2)
boundaries and excitations:
  Radiation1: Radiation Objects=Region
  Port1: Wave Port Objects=WavePort1 NumModes=1 Modes{Mode1{IntLine{(0.345, 0.0275, 0.53281) -> (0.345, 0.0775, 0.53281)} CharImp=Zpi RenormImp=50ohm}}
  Port2: Wave Port Objects=WavePort2 NumModes=1 Modes{Mode1{IntLine{(-0.345, 0.0275, 0.53281) -> (-0.345, 0.0775, 0.53281)} CharImp=Zpi RenormImp=50ohm}}
setups:
  Setup1: HfssDriven MultipleAdaptiveFreqsSetup{Low=0GHz High=30GHz} MaxDeltaS=0.02 MaximumPasses=20 MinimumPasses=1 MinimumConvergedPasses=1 PercentRefinement=30 BasisOrder=1 PortAccuracy=2 DrivenSolverType="Direct Solver"
    sweep Sweep: 0.1GHz to 30GHz step 0.1GHz; Type=Interpolating InterpTolerance=0.5 InterpMaxSolns=250 InterpUsePortImped=false PassivityErrorTolerance=0.0001
source amplitudes:
  Port1:1: 1W 0deg
  Port2:1: 0W 0deg
optimetrics:
  ParametricSetup1: Parametric Sim._Setups=[Setup1]
    sweep $res_width: 114um
    sweep $res_length: 104um
    sweep $sheet_res: 70
    sweep $elevation: LIN 0um 3um 3um
  SheetRes70: Optimization Optimizer="DX MOGA" AnalysisStopOptions{StopForNumIteration StopForGrdTolerance MaxNumIteration=50000100 MinNumIteration=10} CostFuncNormType=L2 Acceptable_Cost=0 Noise=0.0001 UpdateDesignWhenDone
    vary $res_length: Min=85um Max=110um MinStep=0.95um MaxStep=9.5um MinFocus=50um MaxFocus=150um start=85um
    vary $res_width: Min=90um Max=120um MinStep=0.00025mm MaxStep=0.0025mm MinFocus=50um MaxFocus=125um start=90um
    vary $sheet_res: Min=70 Max=70 MinStep=0.7 MaxStep=7 MinFocus=35 MaxFocus=105
    goal dB(S(Port1,Port1)) <= -10 weight 1 on Setup1 : Sweep at Freq 0.1GHz to 30GHz
    goal dB(S(Port2,Port1)) <= -2.9 weight 1 on Setup1 : Sweep at Freq 24.25GHz to 27.5GHz
    goal dB(S(Port2,Port1)) >= -3.1 weight 1 on Setup1 : Sweep at Freq 24.25GHz to 27.5GHz
  SheetRes80: Optimization Optimizer="DX MOGA" AnalysisStopOptions{StopForNumIteration StopForGrdTolerance MaxNumIteration=50000100 MinNumIteration=10} CostFuncNormType=L2 Acceptable_Cost=0 Noise=0.0001 UpdateDesignWhenDone
    vary $res_length: Min=85um Max=110um MinStep=0.95um MaxStep=9.5um MinFocus=50um MaxFocus=150um start=85um
    vary $res_width: Min=90um Max=120um MinStep=0.00025mm MaxStep=0.0025mm MinFocus=50um MaxFocus=125um start=90um
    vary $sheet_res: Min=70 Max=70 MinStep=0.7 MaxStep=7 MinFocus=35 MaxFocus=105
    goal dB(S(Port1,Port1)) <= -10 weight 1 on Setup1 : Sweep at Freq 0.1GHz to 30GHz
    goal dB(S(Port2,Port1)) <= -2.9 weight 1 on Setup1 : Sweep at Freq 24.25GHz to 27.5GHz
    goal dB(S(Port2,Port1)) >= -3.1 weight 1 on Setup1 : Sweep at Freq 24.25GHz to 27.5GHz
  SheetRes90: Optimization Optimizer="DX MOGA" AnalysisStopOptions{StopForNumIteration StopForGrdTolerance MaxNumIteration=50000100 MinNumIteration=10} CostFuncNormType=L2 Acceptable_Cost=0 Noise=0.0001 UpdateDesignWhenDone
    vary $res_length: Min=85um Max=110um MinStep=0.95um MaxStep=9.5um MinFocus=50um MaxFocus=150um start=85um
    vary $res_width: Min=90um Max=120um MinStep=0.00025mm MaxStep=0.0025mm MinFocus=50um MaxFocus=125um start=90um
    vary $sheet_res: Min=70 Max=70 MinStep=0.7 MaxStep=7 MinFocus=35 MaxFocus=105
    goal dB(S(Port1,Port1)) <= -10 weight 1 on Setup1 : Sweep at Freq 0.1GHz to 30GHz
    goal dB(S(Port2,Port1)) <= -2.9 weight 1 on Setup1 : Sweep at Freq 24.25GHz to 27.5GHz
    goal dB(S(Port2,Port1)) >= -3.1 weight 1 on Setup1 : Sweep at Freq 24.25GHz to 27.5GHz
  ParametricSetup2: Parametric Sim._Setups=[Setup1]
    sweep $res_width: 114um
    sweep $res_length: 104um
    sweep $sheet_res: 70
    sweep $elevation: LIN 0um 3um 3um
  ParametricSetup3: Parametric Sim._Setups=[Setup1]
    sweep $res_width: 116um
    sweep $res_length: 103um
    sweep $sheet_res: 70
    sweep $elevation: LIN 0um 3um 3um
  Setup_ShetRes70: Parametric Sim._Setups=[Setup1]
    sweep $res_width: LIN 94um 113um 1um
    sweep $res_length: LIN 93um 102um 1um
    sweep $sheet_res: 70
    sweep $elevation: 3um
    table edits: del(95um, 96um, 70, 3um) del(95um, 95um, 70, 3um) del(95um, 94um, 70, 3um) del(95um, 93um, 70, 3um) del(94um, 102um, 70, 3um) del(94um, 101um, 70, 3um) del(94um, 100um, 70, 3um) del(94um, 99um, 70, 3um) del(94um, 98um, 70, 3um) del(94um, 97um, 70, 3um) del(94um, 96um, 70, 3um) del(94um, 95um, 70, 3um) del(94um, 94um, 70, 3um) del(97um, 93um, 70, 3um) del(96um, 102um, 70, 3um) del(96um, 101um, 70, 3um) del(96um, 100um, 70, 3um) del(96um, 99um, 70, 3um) del(96um, 98um, 70, 3um) del(96um, 97um, 70, 3um) del(96um, 96um, 70, 3um) del(96um, 95um, 70, 3um) del(96um, 94um, 70, 3um) del(96um, 93um, 70, 3um) del(95um, 102um, 70, 3um) del(95um, 101um, 70, 3um) del(95um, 100um, 70, 3um) del(95um, 99um, 70, 3um) del(95um, 98um, 70, 3um) del(95um, 97um, 70, 3um) del(98um, 101um, 70, 3um) del(98um, 100um, 70, 3um) del(98um, 99um, 70, 3um) del(98um, 98um, 70, 3um) del(98um, 97um, 70, 3um) del(98um, 96um, 70, 3um) del(98um, 95um, 70, 3um) del(98um, 94um, 70, 3um) del(98um, 93um, 70, 3um) del(97um, 102um, 70, 3um) del(97um, 101um, 70, 3um) del(97um, 100um, 70, 3um) del(97um, 99um, 70, 3um) del(97um, 98um, 70, 3um) del(97um, 97um, 70, 3um) del(97um, 96um, 70, 3um) del(97um, 95um, 70, 3um) del(97um, 94um, 70, 3um) del(110um, 97um, 70, 3um) del(110um, 96um, 70, 3um) del(110um, 95um, 70, 3um) del(110um, 94um, 70, 3um) del(110um, 93um, 70, 3um) del(109um, 102um, 70, 3um) del(109um, 101um, 70, 3um) del(109um, 100um, 70, 3um) del(109um, 99um, 70, 3um) del(109um, 98um, 70, 3um) del(109um, 97um, 70, 3um) del(109um, 96um, 70, 3um)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
  Setup_ShetRes80: Parametric Sim._Setups=[Setup1]
    sweep $res_width: LIN 94um 120um 1um
    sweep $res_length: LIN 85um 101um 1um
    sweep $sheet_res: 80
    sweep $elevation: 3um
    table edits: del(94um, 86um, 80, 3um) del(94um, 87um, 80, 3um) del(94um, 88um, 80, 3um) del(94um, 89um, 80, 3um) del(94um, 91um, 80, 3um) del(94um, 92um, 80, 3um) del(94um, 93um, 80, 3um) del(94um, 94um, 80, 3um) del(94um, 95um, 80, 3um) del(94um, 96um, 80, 3um) del(94um, 97um, 80, 3um) del(94um, 98um, 80, 3um) del(94um, 99um, 80, 3um) del(94um, 100um, 80, 3um) del(94um, 101um, 80, 3um) del(95um, 85um, 80, 3um) del(95um, 86um, 80, 3um) del(95um, 87um, 80, 3um) del(95um, 88um, 80, 3um) del(95um, 89um, 80, 3um) del(95um, 90um, 80, 3um) del(95um, 91um, 80, 3um) del(95um, 92um, 80, 3um) del(95um, 93um, 80, 3um) del(95um, 94um, 80, 3um) del(95um, 95um, 80, 3um) del(95um, 96um, 80, 3um) del(95um, 97um, 80, 3um) del(95um, 98um, 80, 3um) del(95um, 99um, 80, 3um) del(95um, 100um, 80, 3um) del(95um, 101um, 80, 3um) del(96um, 85um, 80, 3um) del(96um, 86um, 80, 3um) del(96um, 87um, 80, 3um) del(96um, 88um, 80, 3um) del(96um, 89um, 80, 3um) del(96um, 90um, 80, 3um) del(96um, 91um, 80, 3um) del(96um, 92um, 80, 3um) del(96um, 93um, 80, 3um) del(96um, 94um, 80, 3um) del(96um, 95um, 80, 3um) del(96um, 96um, 80, 3um) del(96um, 97um, 80, 3um) del(96um, 98um, 80, 3um) del(96um, 99um, 80, 3um) del(96um, 100um, 80, 3um) del(96um, 101um, 80, 3um) del(97um, 85um, 80, 3um) del(97um, 86um, 80, 3um) del(97um, 87um, 80, 3um) del(97um, 88um, 80, 3um) del(97um, 89um, 80, 3um) del(97um, 90um, 80, 3um) del(97um, 91um, 80, 3um) del(97um, 92um, 80, 3um) del(97um, 93um, 80, 3um) del(97um, 94um, 80, 3um) del(97um, 95um, 80, 3um)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
  Setup_ShetRes90: Parametric Sim._Setups=[Setup1]
    sweep $res_width: LIN 94um 120um 1um
    sweep $res_length: LIN 85um 101um 1um
    sweep $sheet_res: 80
    sweep $elevation: 3um
    table edits: del(94um, 86um, 80, 3um) del(94um, 87um, 80, 3um) del(94um, 88um, 80, 3um) del(94um, 89um, 80, 3um) del(94um, 91um, 80, 3um) del(94um, 92um, 80, 3um) del(94um, 93um, 80, 3um) del(94um, 94um, 80, 3um) del(94um, 95um, 80, 3um) del(94um, 96um, 80, 3um) del(94um, 97um, 80, 3um) del(94um, 98um, 80, 3um) del(94um, 99um, 80, 3um) del(94um, 100um, 80, 3um) del(94um, 101um, 80, 3um) del(95um, 85um, 80, 3um) del(95um, 86um, 80, 3um) del(95um, 87um, 80, 3um) del(95um, 88um, 80, 3um) del(95um, 89um, 80, 3um) del(95um, 90um, 80, 3um) del(95um, 91um, 80, 3um) del(95um, 92um, 80, 3um) del(95um, 93um, 80, 3um) del(95um, 94um, 80, 3um) del(95um, 95um, 80, 3um) del(95um, 96um, 80, 3um) del(95um, 97um, 80, 3um) del(95um, 98um, 80, 3um) del(95um, 99um, 80, 3um) del(95um, 100um, 80, 3um) del(95um, 101um, 80, 3um) del(96um, 85um, 80, 3um) del(96um, 86um, 80, 3um) del(96um, 87um, 80, 3um) del(96um, 88um, 80, 3um) del(96um, 89um, 80, 3um) del(96um, 90um, 80, 3um) del(96um, 91um, 80, 3um) del(96um, 92um, 80, 3um) del(96um, 93um, 80, 3um) del(96um, 94um, 80, 3um) del(96um, 95um, 80, 3um) del(96um, 96um, 80, 3um) del(96um, 97um, 80, 3um) del(96um, 98um, 80, 3um) del(96um, 99um, 80, 3um) del(96um, 100um, 80, 3um) del(96um, 101um, 80, 3um) del(97um, 85um, 80, 3um) del(97um, 86um, 80, 3um) del(97um, 87um, 80, 3um) del(97um, 88um, 80, 3um) del(97um, 89um, 80, 3um) del(97um, 90um, 80, 3um) del(97um, 91um, 80, 3um) del(97um, 92um, 80, 3um) del(97um, 93um, 80, 3um) del(97um, 94um, 80, 3um) del(97um, 95um, 80, 3um)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
reports:
  Membrana Abbssata: dB(S(Port1,Port1)) vs Freq on Setup1 : Sweep [$elevation=0um $res_width=0.055mm $res_length=95um]
  Membrana Alzata: dB(S(Port1,Port1)) vs Freq on Setup1 : Sweep [$elevation=3um $res_width=0.055mm $res_length=95um]
  Sheet resistance 70: dB(S(Port2,Port1)), dB(S(Port1,Port1)) vs Freq on Setup1 : Sweep [$elevation=3um $res_width=119um $res_length=105um $sheet_res=70]
  Sheet resistance 70 - All values: dB(S(Port1,Port1)), dB(S(Port2,Port1)) vs Freq on Setup1 : Sweep [$elevation=3um $res_width=119um $res_length=105um $sheet_res=70]; dB(S(Port2,Port1)), dB(S(Port1,Port1)) vs Freq on Setup1 : Sweep [$elevation=3um $res_width=114um $res_length=104um $sheet_res=70]; dB(S(Port1,Port1)), dB(S(Port2,Port1)) vs Freq on Setup1 : Sweep [$elevation=3um $res_width=116um $res_length=103um $sheet_res=70]; dB(S(Port2,Port1)), dB(S(Port1,Port1)) vs Freq on Setup1 : Sweep [$elevation=3um $res_width=112um $res_length=102um $sheet_res=70]; dB(S(Port1,Port1)), dB(S(Port2,Port1)) vs Freq on Setup1 : Sweep [$elevation=3um $res_width=107um $res_length=99um $sheet_res=70]; dB(S(Port2,Port1)), dB(S(Port1,Port1)) vs Freq on Setup1 : Sweep [$elevation=3um $res_width=100um $res_length=99um $sheet_res=70]; dB(S(Port1,Port1)), dB(S(Port2,Port1)) vs Freq on Setup1 : Sweep [$elevation=3um $res_width=109um $res_length=98um $sheet_res=70]; dB(S(Port2,Port1)), dB(S(Port1,Port1)) vs Freq on Setup1 : Sweep [$elevation=3um $res_width=104um $res_length=97um $sheet_res=70]; dB(S(Port1,Port1)), dB(S(Port2,Port1)) vs Freq on Setup1 : Sweep [$elevation=3um $res_width=101um $res_length=97um $sheet_res=70]; dB(S(Port2,Port1)), dB(S(Port1,Port1)) vs Freq on Setup1 : Sweep [$elevation=3um $res_width=99um $res_length=95um $sheet_res=70]; dB(S(Port1,Port1)), dB(S(Port2,Port1)) vs Freq on Setup1 : Sweep [$elevation=3um $res_width=94um $res_length=93um $sheet_res=70]; dB(S(Port2,Port1)), dB(S(Port1,Port1)) vs Freq on Setup1 : Sweep [$elevation=3um $res_width=103um $res_length=93um $sheet_res=70]
  Sheet resistance 70 - All values S21: dB(S(Port2,Port1)) vs Freq on Setup1 : Sweep [$elevation=3um $res_width=119um $res_length=105um $sheet_res=70]; dB(S(Port2,Port1)) vs Freq on Setup1 : Sweep [$elevation=3um $res_width=114um $res_length=104um $sheet_res=70]; dB(S(Port2,Port1)) vs Freq on Setup1 : Sweep [$elevation=3um $res_width=116um $res_length=103um $sheet_res=70]; dB(S(Port2,Port1)) vs Freq on Setup1 : Sweep [$elevation=3um $res_width=112um $res_length=102um $sheet_res=70]; dB(S(Port2,Port1)) vs Freq on Setup1 : Sweep [$elevation=3um $res_width=107um $res_length=99um $sheet_res=70]; dB(S(Port2,Port1)) vs Freq on Setup1 : Sweep [$elevation=3um $res_width=100um $res_length=99um $sheet_res=70]; dB(S(Port2,Port1)) vs Freq on Setup1 : Sweep [$elevation=3um $res_width=109um $res_length=98um $sheet_res=70]; dB(S(Port2,Port1)) vs Freq on Setup1 : Sweep [$elevation=3um $res_width=104um $res_length=97um $sheet_res=70]; dB(S(Port2,Port1)) vs Freq on Setup1 : Sweep [$elevation=3um $res_width=101um $res_length=97um $sheet_res=70]; dB(S(Port2,Port1)) vs Freq on Setup1 : Sweep [$elevation=3um $res_width=99um $res_length=95um $sheet_res=70]; dB(S(Port2,Port1)) vs Freq on Setup1 : Sweep [$elevation=3um $res_width=94um $res_length=93um $sheet_res=70]; dB(S(Port2,Port1)) vs Freq on Setup1 : Sweep [$elevation=3um $res_width=103um $res_length=93um $sheet_res=70]; markers MX1 at x=2.424e+10, MX2 at x=2.75e+10, MY1 at y=-3.00259
  Sheet resistance 70 - All values S11: dB(S(Port1,Port1)), dB(S(Port1,Port1)), dB(S(Port1,Port1)), dB(S(Port1,Port1)), dB(S(Port1,Port1)), dB(S(Port1,Port1)), dB(S(Port1,Port1)), dB(S(Port1,Port1)), dB(S(Port1,Port1)), dB(S(Port1,Port1)), dB(S(Port1,Port1)), dB(S(Port1,Port1)) vs Freq
  Sheet resistance 80 - All values: dB(S(Port1,Port1)), dB(S(Port2,Port1)) vs Freq on Setup1 : Sweep [$elevation=3um $res_width=120um $res_length=101um $sheet_res=80]; dB(S(Port2,Port1)), dB(S(Port1,Port1)) vs Freq on Setup1 : Sweep [$elevation=3um $res_width=118um $res_length=99um $sheet_res=80]; dB(S(Port1,Port1)), dB(S(Port2,Port1)) vs Freq on Setup1 : Sweep [$elevation=3um $res_width=119um $res_length=97um $sheet_res=80]; dB(S(Port2,Port1)), dB(S(Port1,Port1)) vs Freq on Setup1 : Sweep [$elevation=3um $res_width=114um $res_length=96um $sheet_res=80]; dB(S(Port1,Port1)), dB(S(Port2,Port1)) vs Freq on Setup1 : Sweep [$elevation=3um $res_width=117um $res_length=95um $sheet_res=80]; dB(S(Port2,Port1)), dB(S(Port1,Port1)) vs Freq on Setup1 : Sweep [$elevation=3um $res_width=112um $res_length=94um $sheet_res=80]; dB(S(Port1,Port1)), dB(S(Port2,Port1)) vs Freq on Setup1 : Sweep [$elevation=3um $res_width=102um $res_length=92um $sheet_res=80]; dB(S(Port2,Port1)), dB(S(Port1,Port1)) vs Freq on Setup1 : Sweep [$elevation=3um $res_width=111um $res_length=92um $sheet_res=80]; dB(S(Port1,Port1)), dB(S(Port2,Port1)) vs Freq on Setup1 : Sweep [$elevation=3um $res_width=106um $res_length=91um $sheet_res=80]; dB(S(Port2,Port1)), dB(S(Port1,Port1)) vs Freq on Setup1 : Sweep [$elevation=3um $res_width=108um $res_length=90um $sheet_res=80]; dB(S(Port1,Port1)), dB(S(Port2,Port1)) vs Freq on Setup1 : Sweep [$elevation=3um $res_width=96um $res_length=87um $sheet_res=80]; dB(S(Port2,Port1)), dB(S(Port1,Port1)) vs Freq on Setup1 : Sweep [$elevation=3um $res_width=105um $res_length=87um $sheet_res=80]; dB(S(Port1,Port1)), dB(S(Port2,Port1)) vs Freq on Setup1 : Sweep [$elevation=3um $res_width=98um $res_length=86um $sheet_res=80]; dB(S(Port2,Port1)), dB(S(Port1,Port1)) vs Freq on Setup1 : Sweep [$elevation=3um $res_width=94um $res_length=85um $sheet_res=80]
  Sheet resistance 80 - All values S21: dB(S(Port2,Port1)), dB(S(Port2,Port1)), dB(S(Port2,Port1)), dB(S(Port2,Port1)), dB(S(Port2,Port1)), dB(S(Port2,Port1)), dB(S(Port2,Port1)), dB(S(Port2,Port1)), dB(S(Port2,Port1)), dB(S(Port2,Port1)), dB(S(Port2,Port1)), dB(S(Port2,Port1)), dB(S(Port2,Port1)), dB(S(Port2,Port1)) vs Freq; markers MX1 at x=2.425e+10, MX2 at x=2.75e+10
  Sheet resistance 80 - All values S11: dB(S(Port1,Port1)), dB(S(Port1,Port1)), dB(S(Port1,Port1)), dB(S(Port1,Port1)), dB(S(Port1,Port1)), dB(S(Port1,Port1)), dB(S(Port1,Port1)), dB(S(Port1,Port1)), dB(S(Port1,Port1)), dB(S(Port1,Port1)), dB(S(Port1,Port1)), dB(S(Port1,Port1)), dB(S(Port1,Port1)), dB(S(Port1,Port1)) vs Freq
  Sheet resistance 90 - All values: dB(S(Port1,Port1)), dB(S(Port2,Port1)) vs Freq on Setup1 : Sweep [$elevation=3um $res_width=117um $res_length=91um $sheet_res=90]; dB(S(Port2,Port1)), dB(S(Port1,Port1)) vs Freq on Setup1 : Sweep [$elevation=3um $res_width=113um $res_length=90um $sheet_res=90]; dB(S(Port1,Port1)), dB(S(Port2,Port1)) vs Freq on Setup1 : Sweep [$elevation=3um $res_width=107um $res_length=86um $sheet_res=90]; dB(S(Port2,Port1)), dB(S(Port1,Port1)) vs Freq on Setup1 : Sweep [$elevation=3um $res_width=103um $res_length=85um $sheet_res=90]
  Sheet resistance 90 - All values S21: dB(S(Port2,Port1)), dB(S(Port2,Port1)), dB(S(Port2,Port1)), dB(S(Port2,Port1)) vs Freq; markers MX1 at x=2.425e+10, MX2 at x=2.75e+10
  Sheet resistance 90 - All values S11: dB(S(Port1,Port1)), dB(S(Port1,Port1)), dB(S(Port1,Port1)), dB(S(Port1,Port1)) vs Freq
